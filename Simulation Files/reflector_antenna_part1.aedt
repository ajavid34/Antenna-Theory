# Ansys Electronics Desktop project, version 2022.2
materials:
  vacuum: permittivity=1

design horn (HFSS, DrivenModal, model units mm)
geometry:
  HFSSDesign1_1 = component(HFSSDesign1, 3D_Component_File_Path=C:/Users/hooshmand/Documents/Ansoft/horn_without_airbox.a3dcomp, WG_length=55mm, Horn_length=200mm, a=47.55mm, b=22.15mm, F_a=140mm, F_b=100mm, wall_thickness=0.05mm)
  Horn_air [vacuum] = part_of(HFSSDesign1_1)
  Horn_shell [perfect conductor] = part_of(HFSSDesign1_1)
  wave_port [vacuum] = part_of(HFSSDesign1_1)
  HFSSDesign1_1.rotate(RotateAxis=Y RotateAngle=90deg)
  RadiatingSurface [vacuum] = region(absolute_offset=10mm on all sides)
boundaries and excitations:
  Open1: Radiation Objects=RadiatingSurface
  HFSSDesign1_1_1: Wave Port Objects=wave_port NumModes=1 Modes{Mode1{CharImp=Zpi}}
setups:
  Setup1: HfssDriven Frequency=4.9GHz MaxDeltaS=0.02 MaximumPasses=6 MinimumPasses=1 MinimumConvergedPasses=1 PercentRefinement=30 BasisOrder=1 PortAccuracy=2 DrivenSolverType="Direct Solver" ConstantDelta=0s
    sweep Sweep: 4GHz to 6GHz, 101 points; Type=Interpolating InterpTolerance=0.5 InterpMaxSolns=250 InterpUsePortImped=false PassivityErrorTolerance=0.0001
source amplitudes:
  HFSSDesign1_1_1:1: 1W 0deg
radiation setups:
  3D: Infinite Sphere Theta=0deg..180deg step 2deg Phi=-180deg..180deg step 2deg
  Elevation: Infinite Sphere Theta=-180deg..180deg step 1deg Phi=0deg..90deg step 90deg
  Azimuth: Infinite Sphere Theta=90deg..90deg step 0deg Phi=-180deg..180deg step 1deg
  Infinite Sphere1: Infinite Sphere Theta=0deg..180deg step 2deg Phi=0deg..360deg step 2deg
reports:
  S Parameter Plot 1: dB(S(HFSSDesign1_1_1,HFSSDesign1_1_1)) vs Freq on Setup1 : Sweep
  Gain Plot 1: dB(GainTotal) vs Phi, Theta on Setup1 : LastAdaptive, 3D [Freq=4.9GHz]
  Directivity Plot 1: dB(DirTotal) vs Phi, Theta on Setup1 : LastAdaptive, 3D [Freq=4.9GHz]
